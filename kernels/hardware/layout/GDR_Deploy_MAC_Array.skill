; GDR_Physical_Deploy.skill — Automated layout for dual-core MAC array
; Target: 7nm FinFET / 28nm CMOS process
; Mode:   DETERMINISTIC-CONSTRAINT-BUILD

procedure( GDR_Deploy_MAC_Array(numRows numCols)
    let( (cellName libName macWidth macHeight xOffset yOffset)
        cellName  = "gdr_mac_cell"
        libName   = "GDR_Sovereign_Lib"
        macWidth  = 2.0   ; microns
        macHeight = 2.0   ; microns
        xOffset   = 0.0
        yOffset   = 0.0

        printf("Starting Deterministic MAC Array Deployment: %d x %d\n" numRows numCols)

        ; Instantiate common-centroid array (prevents Vth gradient)
        for(i 0 numRows-1
            for(j 0 numCols-1
                let((posX posY)
                    if( (i % 2) == 0
                        posX = j * macWidth
                        posX = (numCols - 1 - j) * macWidth
                    )
                    posY = i * macHeight

                    dbCreateInst(cvCid cellName libName
                        list(posX posY) "R0" 1)
                )
            )
        )
    )
)

procedure( GDR_Route_Sync_Barrier()
    let( (netName)
        netName = "sync_barrier_net"

        printf("Routing M3 Sync-Barrier for Dual-Core Synchronization...\n")

        ; Metal-3 wide trace: R < 10 mΩ, width = 0.5 µm
        leCreatePath(
            list(list(0 0) list(100 0))
            "Metal3"
            0.5
        )
    )
)

; Execute deployment
cvCid = geGetEditCellView()
GDR_Deploy_MAC_Array(128 128)
GDR_Route_Sync_Barrier()
